# Ansys Electronics Desktop project, version 2025.2
materials:
  vacuum: permittivity=1
  FR4_epoxy: permittivity=4.4 dielectric_loss_tangent=0.02
  air: permittivity=1.0006 permeability=1.0000004

design HFSSDesign1 (HFSS, HFSS Modal Network, model units mm)
geometry:
  Ground = rectangle(corner=((-160/2) mm, (-180/2) mm, 0mm), x_size=160mm, y_size=180mm)
  substrate [FR4_epoxy] = box(corner=((-160/2) mm, (180/2) mm, 0mm), size=(160mm, -180mm, 1.6mm))
  vacuumtest [air] = box(corner=((250/2) mm, (-250/2) mm, (-50/2) mm), size=(-250mm, 250mm, 50mm))
  Patch1 = imported_body()
  Rectangle5 = rectangle(corner=(0.805mm, 10.5mm, 1.6mm), x_size=6mm, y_size=-3.05mm)
  Rectangle6 = rectangle(corner=(6.805mm, 7.45mm, 1.6mm), x_size=3.05mm, y_size=17.8745mm)
  Rectangle7 = rectangle(corner=(9.855mm, 25.3245mm, 1.6mm), x_size=70.145mm, y_size=-3.05mm)
  Patch1.unite(Rectangle5)
  Rectangle6.unite(Rectangle7)
  Rectangle6.chamfer(Vertices=Patch1.vertex(at (6.805, 25.3245, 1.6)) LeftDistance=1.79mm RightDistance=1.79mm ChamferType=Symmetric)
  Patch1.unite(Rectangle6)
  Patch1.move(0mm, -8.975mm, 0.4mm)
  Patch1.move(0mm, -14.8245mm, 0mm)
  LumpedPortV2 = rectangle(corner=((160/2) mm, (-3.05/2) mm, 1.6mm), y_size=3.05mm, z_size=-1.6mm)
  Patch1.move(0mm, 6.8833828e-15mm, -0.4mm)
boundaries and excitations:
  Rad1: Radiation Objects=vacuumtest
  PerfE1: Perfect E Objects=Ground
  PerfE2: Perfect E Objects=Patch1
  1: Lumped Port Objects=LumpedPortV2 LumpedPortType=Modal Modes{Mode1{IntLine{(80, 0, 0) -> (80, 0, 1.6)} CharImp=Zpi RenormImp=50ohm}} Impedance=50ohm
mesh:
  Length1: LengthBased Objects=Patch1 NumMaxElem=64000 MaxLength=23.841mm
setups:
  Setup1: HfssDriven Frequency=3GHz MaxDeltaS=0.03 MaximumPasses=10 MinimumPasses=1 MinimumConvergedPasses=1 PercentRefinement=30 BasisOrder=1 PortAccuracy=2 DrivenSolverType="Direct Solver"
    sweep Sweep: 1.5GHz to 4.5GHz step 0.1GHz; Type=Fast SaveFields
source amplitudes:
  1:1: 1W 0deg
radiation setups:
  Infinite Sphere1: Infinite Sphere Theta=0deg..360deg step 10deg Phi=0deg..0deg step 0deg
reports:
  S Parameter Plot1: dB(S(1,1)) vs Freq on Setup1 : Sweep
  VSWR Plot1: VSWR(1) vs Freq on Setup1 : Sweep
  rE Plot1: rETotal vs Theta on Setup1 : LastAdaptive, Infinite Sphere1 [Phi=all Freq=3GHz]
  Antenna Params Plot1: PeakDirectivity vs Freq on Setup1 : LastAdaptive
  Antenna Params Plot2: PeakDirectivity vs Freq on Setup1 : Sweep
  Antenna Params Table1: TotalEfficiency vs Freq on Setup1 : LastAdaptive
  Antenna Params Table2: TotalEfficiency vs Freq on Setup1 : Sweep
  Antenna Params Table3: RadiationEfficiency vs Freq on Setup1 : LastAdaptive
  Antenna Params Table4: RadiationEfficiency vs Freq on Setup1 : LastAdaptive
  Antenna Params Table5: RadiationEfficiency vs Freq on Setup1 : Sweep
